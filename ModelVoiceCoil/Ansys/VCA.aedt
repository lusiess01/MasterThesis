# Ansys Electronics Desktop project, version 2024.2
materials:
  vacuum: permittivity=1
  copper: permeability=0.999991 conductivity=58000000

design Maxwell3DDesign1 (Maxwell 3D, Magnetostatic, model units mm)
variables:
  wire = 0.05mm
  N = 40
  coil = 6mm
  m = 2.4mm
geometry:
  Region [vacuum] = box(corner=(18.081505mm, 18.081505mm, -4.1700005mm), size=(-36.163009mm, -36.163009mm, 12.360001mm))
  point 1 = (5.7995mm, 0mm, 0mm)
  point 1 = (0mm, 0mm, 0mm)
  Spule = imported_body(D:\11_GIT\MasterThesis\ModelVoiceCoil\Spule\Spule.stp)
  Cylinder1 = cylinder(axis=Y, base_centre=(6mm, -12mm, 0mm), radius=0.04mm, height=-12mm)
  Coil [vacuum, non-model] = cylinder(axis=Y, base_centre=(4.9995mm, 12.17mm, 4.04mm), radius=0.040003125mm, height=13.83mm)
  Cylinder1.split(plane=Region_1.face(3 of 6), keep=PositiveOnly)
  Region_1 = Region.copy()
  Region_1.delete()
  Coil.split(plane=Region_2.face(5 of 6), keep=PositiveOnly)
  Region_2 = Region.copy()
  Region_2.delete()
  Coil.unite(Spule, Cylinder1)
  Coil_easy [copper] = cylinder(axis=Z, base_centre=(0mm, 0mm, 0mm), radius=6mm, height=4mm)
  Cylinder3 = cylinder(axis=Z, base_centre=(0mm, 0mm, 0mm), radius=5.6320511mm, height=4mm)
  Coil_easy.subtract(Cylinder3)
  Coil_easy_Section1 = Coil_easy.section(plane=ZX)
  Coil_easy_Section1_Separate1 [copper] = Coil_easy_Section1.separate_bodies()
  Coil_easy_Section1.delete()
boundaries and excitations:
  CoilTerminal1: Coil Terminal Objects=Coil_easy_Section1_Separate1 Conductor_number=40*3 Winding=Winding1 Point_out_of_terminal=false
  Winding1: Winding Group Type=Current IsSolid=false Current=1A ParallelBranchesNum=1
parameters:
  Matrix1: Matrix Winding1: NumberOfTurns=1
mesh:
  Length1: LengthBased RefineInside Objects=Coil_easy MaxLength=2.4/m
  initial mesh: GlobalCurvilinear{Apply}
setups:
  Setup1: Magnetostatic MaximumPasses=10 MinimumPasses=2 MinimumConvergedPasses=1 PercentRefinement=30 PercentError=1 NonLinearResidual=0.001
