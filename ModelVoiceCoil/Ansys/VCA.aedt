# Ansys Electronics Desktop project, version 2024.2
materials:
  vacuum: permittivity=1
  copper: permeability=0.999991 conductivity=58000000

design Maxwell3DDesign1 (Maxwell 3D, Magnetostatic, model units mm)
variables:
  wire = 0.05mm
  N = 40
  coil = 6mm
geometry:
  Region [vacuum] = box(corner=(18.081505mm, 18.081505mm, -4.1700005mm), size=(-36.163009mm, -36.163009mm, 12.360001mm))
  point 1 = (5.7995mm, 0mm, 0mm)
  point 1 = (0mm, 0mm, 0mm)
  Spule [copper] = imported_body(D:\11_GIT\MasterThesis\ModelVoiceCoil\Spule\Spule.stp)
boundaries and excitations:
  Out: Coil Terminal Faces=Spule.face(at (4.9995, 12.17, 4.04)) Conductor_number=1 Winding=-1 Point_out_of_terminal=true
  In: Coil Terminal Faces=Spule.face(at (6, -12, 0)) Conductor_number=1 Winding=-1 Point_out_of_terminal=false
mesh:
  initial mesh: GlobalCurvilinear{Apply}
